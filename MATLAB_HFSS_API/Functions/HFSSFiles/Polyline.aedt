# Ansys Electronics Desktop project, version 2021.1
materials:
  vacuum: permittivity=1

design Design1 (HFSS, DrivenModal, model units mm)
variables:
  t = 18um
  X_sub = 3mm
  Y_sub = 3mm
  Z_sub = 1.57mm
  Port_h = 100mm
  port_l = 0.813mm
  port_w = 0.4mm
  sub_h = 0.813mm
  tap_w = 1.5mm
  wavelength = 75mm
  wavelength_g = 40mm
  gnd_h = 8mm
  L = 3.0935mm
  W = 3mm
  sp = 0.15mm
  sW = (W - 4*sp)/5
  sL = W/2 + sp
  m = 5
  n = 5
  dx = 2*L+2*tap_w+port_l
  dy = 2*(2*L+2*tap_w+port_l)
  Sub_offset = dx
  gnd_offset = dx/2
  gslot = 2mm
  Ht = gnd_h
  moveX = dx
  moveY = dy
geometry:
  Polyline2 = polyline(z=0, xy: (-port_l/2, -port_w/2) (-port_l/2 - tap_w, -W/2) (-port_l/2 - tap_w - L, -W/2) (-port_l/2 - tap_w - L, -W/2 + sW) (-port_l/2 - tap_w - L + sL, -W/2 + sW) (-port_l/2 - tap_w - L + sL, -sW/2) (-port_l/2 - tap_w - L, -sW/2) (-port_l/2 - tap_w - L, sW/2) (-port_l/2 - tap_w - L + sL, sW/2) (-port_l/2 - tap_w - L + sL, W/2 - sW) (-port_l/2 - tap_w - L, W/2 - sW) (-port_l/2 - tap_w - L, W/2) (-port_l/2 - tap_w, W/2) (-port_l/2, port_w/2) (-port_l/2, -port_w/2), closed, covered)
